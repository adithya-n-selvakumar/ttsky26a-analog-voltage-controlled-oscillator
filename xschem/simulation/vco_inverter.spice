** sch_path: /home/ttuser/ttsky26a-analog-voltage-controlled-oscillator/xschem/vco_inverter.sch
.subckt vco_inverter VDD VIN_INV VOUT_INV VSS
*.PININFO VDD:B VSS:B VIN_INV:I VOUT_INV:O
XM1 VOUT_INV VIN_INV VSS VSS sky130_fd_pr__nfet_01v8 L=0.15 W=1 nf=1 m=1
XM2 VOUT_INV VIN_INV VDD VDD sky130_fd_pr__pfet_01v8 L=0.15 W=1 nf=1 m=1
.ends
.end
